* Automated WPD sweep for 6T SRAM Cell: SNM & Write Trip Point / Margin
.include "../tsmc018.lib"

Vdd vdd 0 DC 1.8
Vbl bl 0 DC 1.8
Vblb blb 0 DC 1.8
Vwl wl 0 DC 1.8

* Sweep setup
V_in1 q_in 0 DC 0

* Define circuit with parameter WPD_val
.param WPD_val = 0.54u
Mpd1 qb_out q_in 0   0   CMOSN W={WPD_val} L=0.18u
Mpu1 qb_out q_in vdd vdd CMOSP W=0.28u     L=0.18u
Mpg1 blb    wl   qb_out 0 CMOSN W=0.36u     L=0.18u

.control
let wpd_list = vector(5)
let wpd_list[0] = 0.28u
let wpd_list[1] = 0.36u
let wpd_list[2] = 0.44u
let wpd_list[3] = 0.54u
let wpd_list[4] = 0.65u

let i = 0
while i < 5
  alterparam WPD_val = $&wpd_list[i]
  reset
  dc V_in1 0 1.8 0.005
  set wr_vecnames
  let outfile = "sweep_wpd_" + $&i + ".txt"
  wrdata $outfile v(qb_out)
  let i = i + 1
end
quit
.endc
.end
