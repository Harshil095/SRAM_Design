*** SPICE deck for cell Col_Mux_Bank_16{sch} from library SRAM
*** Created on Tue Nov 17, 2026 00:46:20
*** Last revised on Tue Nov 17, 2026 00:46:20
*** Written on Tue Nov 17, 2026 04:43:08 by Electric VLSI Design System, version 9.08
*** Layout tech: mocmos, foundry MOSIS
*** UC SPICE *** , MIN_RESIST 4.0, MIN_CAPAC 0.1FF

*** SUBCIRCUIT SRAM__tgate FROM CELL SRAM:tgate{sch}
.SUBCKT SRAM__tgate EN ENB gnd IN OUT vdd
** GLOBAL gnd
** GLOBAL vdd
Mnmos@0 IN EN OUT gnd CMOSN L=0.4U W=1.6U
Mpmos@0 OUT ENB IN vdd CMOSP L=0.4U W=2.4U
.ENDS SRAM__tgate

*** SUBCIRCUIT SRAM__col_mux_1x FROM CELL SRAM:col_mux_1x{sch}
.SUBCKT SRAM__col_mux_1x BL BLB COL_SEL COL_SEL_B GBL GBLB gnd vdd
** GLOBAL gnd
** GLOBAL vdd
Xtgate@0 COL_SEL COL_SEL_B gnd BL GBL vdd SRAM__tgate
Xtgate@1 COL_SEL COL_SEL_B gnd BLB GBLB vdd SRAM__tgate

* Spice Code nodes in cell cell 'SRAM:col_mux_1x{sch}'
.include ./tsmc018.lib
.param VDD = 1.8
VDD1 vdd 0 DC 1.8
* Load capacitors on Global Bitlines
Cgbl  GBL  0 50f
Cgblb GBLB 0 50f
* Column bitlines carry a Read-0 differential:
* BL = 1.65V (150mV dip) BLB = 1.80V
VBL  BL  0 DC 1.65
VBLB BLB 0 DC 1.80
* Column Select (COL_SEL active-high COL_SEL_B active-low):
* OFF from 0ns to 5ns (High-Z isolation)
* ON from 5ns to 25ns (passes the bitlines to GBL and GBLB)
* OFF from 25ns to 30ns (isolates again)
VSEL COL_SEL 0 PWL(0n 0 4.9n 0 5n 1.8 25n 1.8 25.1n 0 30n 0)
VSEL_B COL_SEL_B 0 PWL(0n 1.8 4.9n 1.8 5n 0 25n 0 25.1n 1.8 30n 1.8)
.tran 0.1n 30n
.ENDS SRAM__col_mux_1x

.global gnd vdd

*** TOP LEVEL CELL: SRAM:Col_Mux_Bank_16{sch}
Xcol_mux_@0 BL[0] BLB[0] COL_SEL[0] COL_SEL_B[0] GBL GBLB gnd vdd SRAM__col_mux_1x
Xcol_mux_@1 BL[1] BLB[1] COL_SEL[1] COL_SEL_B[1] GBL GBLB gnd vdd SRAM__col_mux_1x
Xcol_mux_@2 BL[2] BLB[2] COL_SEL[2] COL_SEL_B[2] GBL GBLB gnd vdd SRAM__col_mux_1x
Xcol_mux_@3 BL[3] BLB[3] COL_SEL[3] COL_SEL_B[3] GBL GBLB gnd vdd SRAM__col_mux_1x
Xcol_mux_@4 BL[4] BLB[4] COL_SEL[4] COL_SEL_B[4] GBL GBLB gnd vdd SRAM__col_mux_1x
Xcol_mux_@5 BL[5] BLB[5] COL_SEL[5] COL_SEL_B[5] GBL GBLB gnd vdd SRAM__col_mux_1x
Xcol_mux_@6 BL[6] BLB[6] COL_SEL[6] COL_SEL_B[6] GBL GBLB gnd vdd SRAM__col_mux_1x
Xcol_mux_@7 BL[7] BLB[7] COL_SEL[7] COL_SEL_B[7] GBL GBLB gnd vdd SRAM__col_mux_1x
Xcol_mux_@8 BL[8] BLB[8] COL_SEL[8] COL_SEL_B[8] GBL GBLB gnd vdd SRAM__col_mux_1x
Xcol_mux_@9 BL[9] BLB[9] COL_SEL[9] COL_SEL_B[9] GBL GBLB gnd vdd SRAM__col_mux_1x
Xcol_mux_@10 BL[10] BLB[10] COL_SEL[10] COL_SEL_B[10] GBL GBLB gnd vdd SRAM__col_mux_1x
Xcol_mux_@11 BL[11] BLB[11] COL_SEL[11] COL_SEL_B[11] GBL GBLB gnd vdd SRAM__col_mux_1x
Xcol_mux_@12 BL[12] BLB[12] COL_SEL[12] COL_SEL_B[12] GBL GBLB gnd vdd SRAM__col_mux_1x
Xcol_mux_@13 BL[13] BLB[13] COL_SEL[13] COL_SEL_B[13] GBL GBLB gnd vdd SRAM__col_mux_1x
Xcol_mux_@14 BL[14] BLB[14] COL_SEL[14] COL_SEL_B[14] GBL GBLB gnd vdd SRAM__col_mux_1x
Xcol_mux_@15 BL[15] BLB[15] COL_SEL[15] COL_SEL_B[15] GBL GBLB gnd vdd SRAM__col_mux_1x
.END
