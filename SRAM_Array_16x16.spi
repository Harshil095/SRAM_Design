*** SPICE deck for cell SRAM_Array_16x16{sch} from library SRAM
*** Created on Tue Nov 17, 2026 00:46:20
*** Last revised on Tue Nov 17, 2026 00:46:20
*** Written on Tue Nov 17, 2026 04:43:07 by Electric VLSI Design System, version 9.08
*** Layout tech: mocmos, foundry MOSIS
*** UC SPICE *** , MIN_RESIST 4.0, MIN_CAPAC 0.1FF

*** SUBCIRCUIT SRAM__6T FROM CELL SRAM:6T{sch}
.SUBCKT SRAM__6T BL BLB gnd vdd WL
** GLOBAL gnd
** GLOBAL vdd
Mnmos@0 net@4 net@9 gnd gnd cmosn L=0.4U W=1.2U
Mnmos@1 net@9 net@4 gnd gnd cmosn L=0.4U W=1.2U
Mnmos@2 BL WL net@9 gnd cmosn L=0.4U W=0.8U
Mnmos@3 net@4 WL BLB gnd cmosn L=0.4U W=0.8U
Mpmos@0 vdd net@4 net@9 vdd cmosp L=0.4U W=0.6U
Mpmos@1 vdd net@9 net@4 vdd cmosp L=0.4U W=0.6U

* Spice Code nodes in cell cell 'SRAM:6T{sch}'
.include ./tsmc018.lib
Vsup vdd 0 1.8
Cbl bl 0 200f
Cblb blb 0 200f
.model swm sw(vt=0.9 vh=0.1 ron=200 roff=1e12)
Sbl dbl bl en 0 swm
Sblb dblb blb en 0 swm
Ven en 0 PWL(0 1.8 10n 1.8 10.1n 0 14.9n 0 15n 1.8 27n 1.8 27.1n 0 31.9n 0 32n 1.8 38n 1.8)
Vdbl dbl 0 PWL(0 0 6.5n 0 7n 1.8 38n 1.8)
Vdblb dblb 0 PWL(0 1.8 18n 1.8 18.5n 0 23.5n 0 24n 1.8 38n 1.8)
Vwl wl 0 PWL(0 0 2n 0 2.1n 1.8 6n 1.8 6.1n 0 11n 0 11.1n 1.8 14n 1.8 14.1n 0 19n 0 19.1n 1.8 23n 1.8 23.1n 0 28n 0 28.1n 1.8 31n 1.8 31.1n 0 38n 0)
.tran 10p 38n
.ENDS SRAM__6T

*** SUBCIRCUIT SRAM__SRAM_Row_16 FROM CELL SRAM:SRAM_Row_16{sch}
.SUBCKT SRAM__SRAM_Row_16 BL[15] BL[14] BL[13] BL[12] BL[11] BL[10] BL[9] BL[8] BL[7] BL[6] BL[5] BL[4] BL[3] BL[2] BL[1] BL[0] BLB[15] BLB[14] BLB[13] BLB[12] BLB[11] BLB[10] BLB[9] BLB[8] BLB[7] BLB[6] BLB[5] BLB[4] BLB[3] BLB[2] BLB[1] BLB[0] gnd vdd WL
** GLOBAL gnd
** GLOBAL vdd
X_6T@0 BL[0] BLB[0] gnd vdd WL SRAM__6T
X_6T@1 BL[1] BLB[1] gnd vdd WL SRAM__6T
X_6T@2 BL[2] BLB[2] gnd vdd WL SRAM__6T
X_6T@3 BL[3] BLB[3] gnd vdd WL SRAM__6T
X_6T@4 BL[4] BLB[4] gnd vdd WL SRAM__6T
X_6T@5 BL[5] BLB[5] gnd vdd WL SRAM__6T
X_6T@6 BL[6] BLB[6] gnd vdd WL SRAM__6T
X_6T@7 BL[7] BLB[7] gnd vdd WL SRAM__6T
X_6T@8 BL[8] BLB[8] gnd vdd WL SRAM__6T
X_6T@9 BL[9] BLB[9] gnd vdd WL SRAM__6T
X_6T@10 BL[10] BLB[10] gnd vdd WL SRAM__6T
X_6T@11 BL[11] BLB[11] gnd vdd WL SRAM__6T
X_6T@12 BL[12] BLB[12] gnd vdd WL SRAM__6T
X_6T@13 BL[13] BLB[13] gnd vdd WL SRAM__6T
X_6T@14 BL[14] BLB[14] gnd vdd WL SRAM__6T
X_6T@15 BL[15] BLB[15] gnd vdd WL SRAM__6T
.ENDS SRAM__SRAM_Row_16

.global gnd vdd

*** TOP LEVEL CELL: SRAM:SRAM_Array_16x16{sch}
XSRAM_Row@0 BL[15] BL[14] BL[13] BL[12] BL[11] BL[10] BL[9] BL[8] BL[7] BL[6] BL[5] BL[4] BL[3] BL[2] BL[1] BL[0] BLB[15] BLB[14] BLB[13] BLB[12] BLB[11] BLB[10] BLB[9] BLB[8] BLB[7] BLB[6] BLB[5] BLB[4] BLB[3] BLB[2] BLB[1] BLB[0] gnd vdd WL[0] SRAM__SRAM_Row_16
XSRAM_Row@1 BL[15] BL[14] BL[13] BL[12] BL[11] BL[10] BL[9] BL[8] BL[7] BL[6] BL[5] BL[4] BL[3] BL[2] BL[1] BL[0] BLB[15] BLB[14] BLB[13] BLB[12] BLB[11] BLB[10] BLB[9] BLB[8] BLB[7] BLB[6] BLB[5] BLB[4] BLB[3] BLB[2] BLB[1] BLB[0] gnd vdd WL[1] SRAM__SRAM_Row_16
XSRAM_Row@2 BL[15] BL[14] BL[13] BL[12] BL[11] BL[10] BL[9] BL[8] BL[7] BL[6] BL[5] BL[4] BL[3] BL[2] BL[1] BL[0] BLB[15] BLB[14] BLB[13] BLB[12] BLB[11] BLB[10] BLB[9] BLB[8] BLB[7] BLB[6] BLB[5] BLB[4] BLB[3] BLB[2] BLB[1] BLB[0] gnd vdd WL[2] SRAM__SRAM_Row_16
XSRAM_Row@3 BL[15] BL[14] BL[13] BL[12] BL[11] BL[10] BL[9] BL[8] BL[7] BL[6] BL[5] BL[4] BL[3] BL[2] BL[1] BL[0] BLB[15] BLB[14] BLB[13] BLB[12] BLB[11] BLB[10] BLB[9] BLB[8] BLB[7] BLB[6] BLB[5] BLB[4] BLB[3] BLB[2] BLB[1] BLB[0] gnd vdd WL[3] SRAM__SRAM_Row_16
XSRAM_Row@4 BL[15] BL[14] BL[13] BL[12] BL[11] BL[10] BL[9] BL[8] BL[7] BL[6] BL[5] BL[4] BL[3] BL[2] BL[1] BL[0] BLB[15] BLB[14] BLB[13] BLB[12] BLB[11] BLB[10] BLB[9] BLB[8] BLB[7] BLB[6] BLB[5] BLB[4] BLB[3] BLB[2] BLB[1] BLB[0] gnd vdd WL[4] SRAM__SRAM_Row_16
XSRAM_Row@5 BL[15] BL[14] BL[13] BL[12] BL[11] BL[10] BL[9] BL[8] BL[7] BL[6] BL[5] BL[4] BL[3] BL[2] BL[1] BL[0] BLB[15] BLB[14] BLB[13] BLB[12] BLB[11] BLB[10] BLB[9] BLB[8] BLB[7] BLB[6] BLB[5] BLB[4] BLB[3] BLB[2] BLB[1] BLB[0] gnd vdd WL[5] SRAM__SRAM_Row_16
XSRAM_Row@6 BL[15] BL[14] BL[13] BL[12] BL[11] BL[10] BL[9] BL[8] BL[7] BL[6] BL[5] BL[4] BL[3] BL[2] BL[1] BL[0] BLB[15] BLB[14] BLB[13] BLB[12] BLB[11] BLB[10] BLB[9] BLB[8] BLB[7] BLB[6] BLB[5] BLB[4] BLB[3] BLB[2] BLB[1] BLB[0] gnd vdd WL[6] SRAM__SRAM_Row_16
XSRAM_Row@7 BL[15] BL[14] BL[13] BL[12] BL[11] BL[10] BL[9] BL[8] BL[7] BL[6] BL[5] BL[4] BL[3] BL[2] BL[1] BL[0] BLB[15] BLB[14] BLB[13] BLB[12] BLB[11] BLB[10] BLB[9] BLB[8] BLB[7] BLB[6] BLB[5] BLB[4] BLB[3] BLB[2] BLB[1] BLB[0] gnd vdd WL[7] SRAM__SRAM_Row_16
XSRAM_Row@8 BL[15] BL[14] BL[13] BL[12] BL[11] BL[10] BL[9] BL[8] BL[7] BL[6] BL[5] BL[4] BL[3] BL[2] BL[1] BL[0] BLB[15] BLB[14] BLB[13] BLB[12] BLB[11] BLB[10] BLB[9] BLB[8] BLB[7] BLB[6] BLB[5] BLB[4] BLB[3] BLB[2] BLB[1] BLB[0] gnd vdd WL[8] SRAM__SRAM_Row_16
XSRAM_Row@9 BL[15] BL[14] BL[13] BL[12] BL[11] BL[10] BL[9] BL[8] BL[7] BL[6] BL[5] BL[4] BL[3] BL[2] BL[1] BL[0] BLB[15] BLB[14] BLB[13] BLB[12] BLB[11] BLB[10] BLB[9] BLB[8] BLB[7] BLB[6] BLB[5] BLB[4] BLB[3] BLB[2] BLB[1] BLB[0] gnd vdd WL[9] SRAM__SRAM_Row_16
XSRAM_Row@10 BL[15] BL[14] BL[13] BL[12] BL[11] BL[10] BL[9] BL[8] BL[7] BL[6] BL[5] BL[4] BL[3] BL[2] BL[1] BL[0] BLB[15] BLB[14] BLB[13] BLB[12] BLB[11] BLB[10] BLB[9] BLB[8] BLB[7] BLB[6] BLB[5] BLB[4] BLB[3] BLB[2] BLB[1] BLB[0] gnd vdd WL[10] SRAM__SRAM_Row_16
XSRAM_Row@11 BL[15] BL[14] BL[13] BL[12] BL[11] BL[10] BL[9] BL[8] BL[7] BL[6] BL[5] BL[4] BL[3] BL[2] BL[1] BL[0] BLB[15] BLB[14] BLB[13] BLB[12] BLB[11] BLB[10] BLB[9] BLB[8] BLB[7] BLB[6] BLB[5] BLB[4] BLB[3] BLB[2] BLB[1] BLB[0] gnd vdd WL[11] SRAM__SRAM_Row_16
XSRAM_Row@12 BL[15] BL[14] BL[13] BL[12] BL[11] BL[10] BL[9] BL[8] BL[7] BL[6] BL[5] BL[4] BL[3] BL[2] BL[1] BL[0] BLB[15] BLB[14] BLB[13] BLB[12] BLB[11] BLB[10] BLB[9] BLB[8] BLB[7] BLB[6] BLB[5] BLB[4] BLB[3] BLB[2] BLB[1] BLB[0] gnd vdd WL[12] SRAM__SRAM_Row_16
XSRAM_Row@13 BL[15] BL[14] BL[13] BL[12] BL[11] BL[10] BL[9] BL[8] BL[7] BL[6] BL[5] BL[4] BL[3] BL[2] BL[1] BL[0] BLB[15] BLB[14] BLB[13] BLB[12] BLB[11] BLB[10] BLB[9] BLB[8] BLB[7] BLB[6] BLB[5] BLB[4] BLB[3] BLB[2] BLB[1] BLB[0] gnd vdd WL[13] SRAM__SRAM_Row_16
XSRAM_Row@14 BL[15] BL[14] BL[13] BL[12] BL[11] BL[10] BL[9] BL[8] BL[7] BL[6] BL[5] BL[4] BL[3] BL[2] BL[1] BL[0] BLB[15] BLB[14] BLB[13] BLB[12] BLB[11] BLB[10] BLB[9] BLB[8] BLB[7] BLB[6] BLB[5] BLB[4] BLB[3] BLB[2] BLB[1] BLB[0] gnd vdd WL[14] SRAM__SRAM_Row_16
XSRAM_Row@15 BL[15] BL[14] BL[13] BL[12] BL[11] BL[10] BL[9] BL[8] BL[7] BL[6] BL[5] BL[4] BL[3] BL[2] BL[1] BL[0] BLB[15] BLB[14] BLB[13] BLB[12] BLB[11] BLB[10] BLB[9] BLB[8] BLB[7] BLB[6] BLB[5] BLB[4] BLB[3] BLB[2] BLB[1] BLB[0] gnd vdd WL[15] SRAM__SRAM_Row_16
.END
