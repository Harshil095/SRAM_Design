*** SPICE deck for cell SRAM_Chip_Final{sch} from library SRAM.jelib
*** Created on Wed Nov 18, 2026 13:50:17
*** Last revised on Wed Nov 18, 2026 13:50:17
*** Written on Wed Nov 18, 2026 16:04:38 by Electric VLSI Design System, version 9.08
*** Layout tech: mocmos, foundry MOSIS
*** UC SPICE *** , MIN_RESIST 4.0, MIN_CAPAC 0.1FF

*** SUBCIRCUIT SRAM_jelib__inverter FROM CELL SRAM.jelib:inverter{sch}
.SUBCKT SRAM_jelib__inverter in out
** GLOBAL gnd
** GLOBAL vdd
Mnmos@0 out in gnd gnd CMOSN L=0.4U W=0.8U
Mpmos@0 vdd in out vdd CMOSP L=0.4U W=1.6U
.ENDS SRAM_jelib__inverter

*** SUBCIRCUIT SRAM_jelib__inv_3x FROM CELL SRAM.jelib:inv_3x{sch}
.SUBCKT SRAM_jelib__inv_3x gnd in out vdd
** GLOBAL gnd
** GLOBAL vdd
Xinverter@0 in out SRAM_jelib__inverter
Xinverter@1 in out SRAM_jelib__inverter
Xinverter@2 in out SRAM_jelib__inverter
.ENDS SRAM_jelib__inv_3x

*** SUBCIRCUIT SRAM_jelib__Input_Pad FROM CELL SRAM.jelib:Input_Pad{sch}
.SUBCKT SRAM_jelib__Input_Pad CHIP_OUT gnd PAD_IN vdd
** GLOBAL gnd
** GLOBAL vdd
Xinv_3x@0 gnd net@1 CHIP_OUT vdd SRAM_jelib__inv_3x
Xinverter@0 PAD_IN net@1 SRAM_jelib__inverter
.ENDS SRAM_jelib__Input_Pad

*** SUBCIRCUIT SRAM_jelib__inv_9x FROM CELL SRAM.jelib:inv_9x{sch}
.SUBCKT SRAM_jelib__inv_9x gnd in out vdd
** GLOBAL gnd
** GLOBAL vdd
Xinverter@0 in out SRAM_jelib__inverter
Xinverter@1 in out SRAM_jelib__inverter
Xinverter@2 in out SRAM_jelib__inverter
Xinverter@3 in out SRAM_jelib__inverter
Xinverter@4 in out SRAM_jelib__inverter
Xinverter@5 in out SRAM_jelib__inverter
Xinverter@6 in out SRAM_jelib__inverter
Xinverter@7 in out SRAM_jelib__inverter
Xinverter@8 in out SRAM_jelib__inverter
.ENDS SRAM_jelib__inv_9x

*** SUBCIRCUIT SRAM_jelib__inv_27x FROM CELL SRAM.jelib:inv_27x{sch}
.SUBCKT SRAM_jelib__inv_27x gnd in out vdd
** GLOBAL gnd
** GLOBAL vdd
Xinverter@0 in out SRAM_jelib__inverter
Xinverter@1 in out SRAM_jelib__inverter
Xinverter@2 in out SRAM_jelib__inverter
Xinverter@3 in out SRAM_jelib__inverter
Xinverter@4 in out SRAM_jelib__inverter
Xinverter@5 in out SRAM_jelib__inverter
Xinverter@6 in out SRAM_jelib__inverter
Xinverter@7 in out SRAM_jelib__inverter
Xinverter@8 in out SRAM_jelib__inverter
Xinverter@9 in out SRAM_jelib__inverter
Xinverter@10 in out SRAM_jelib__inverter
Xinverter@11 in out SRAM_jelib__inverter
Xinverter@12 in out SRAM_jelib__inverter
Xinverter@13 in out SRAM_jelib__inverter
Xinverter@14 in out SRAM_jelib__inverter
Xinverter@15 in out SRAM_jelib__inverter
Xinverter@16 in out SRAM_jelib__inverter
Xinverter@17 in out SRAM_jelib__inverter
Xinverter@18 in out SRAM_jelib__inverter
Xinverter@19 in out SRAM_jelib__inverter
Xinverter@20 in out SRAM_jelib__inverter
Xinverter@21 in out SRAM_jelib__inverter
Xinverter@22 in out SRAM_jelib__inverter
Xinverter@23 in out SRAM_jelib__inverter
Xinverter@24 in out SRAM_jelib__inverter
Xinverter@25 in out SRAM_jelib__inverter
Xinverter@26 in out SRAM_jelib__inverter
.ENDS SRAM_jelib__inv_27x

*** SUBCIRCUIT SRAM_jelib__Output_Pad FROM CELL SRAM.jelib:Output_Pad{sch}
.SUBCKT SRAM_jelib__Output_Pad CHIP_IN gnd PAD_OUT vdd
** GLOBAL gnd
** GLOBAL vdd
Xinv_3x@0 gnd net@1 net@2 vdd SRAM_jelib__inv_3x
Xinv_9x@0 gnd net@2 net@3 vdd SRAM_jelib__inv_9x
Xinv_27x@0 gnd net@3 PAD_OUT vdd SRAM_jelib__inv_27x
Xinverter@0 CHIP_IN net@1 SRAM_jelib__inverter
.ENDS SRAM_jelib__Output_Pad

*** SUBCIRCUIT SRAM_jelib__nand4 FROM CELL SRAM.jelib:nand4{sch}
.SUBCKT SRAM_jelib__nand4 A B C D out
** GLOBAL gnd
** GLOBAL vdd
Mnmos@4 out A net@62 gnd CMOSN L=0.4U W=3.2U
Mnmos@5 net@62 B net@63 gnd CMOSN L=0.4U W=3.2U
Mnmos@6 net@63 C net@64 gnd CMOSN L=0.4U W=3.2U
Mnmos@7 net@64 D gnd gnd CMOSN L=0.4U W=3.2U
Mpmos@4 vdd A out vdd CMOSP L=0.4U W=1.6U
Mpmos@5 vdd B out vdd CMOSP L=0.4U W=1.6U
Mpmos@7 vdd C out vdd CMOSP L=0.4U W=1.6U
Mpmos@8 vdd D out vdd CMOSP L=0.4U W=1.6U
.ENDS SRAM_jelib__nand4

*** SUBCIRCUIT SRAM_jelib__Decoder_4x16 FROM CELL SRAM.jelib:Decoder_4x16{sch}
.SUBCKT SRAM_jelib__Decoder_4x16 A[3] A[2] A[1] A[0] gnd OUT[15] OUT[14] OUT[13] OUT[12] OUT[11] OUT[10] OUT[9] OUT[8] OUT[7] OUT[6] OUT[5] OUT[4] OUT[3] OUT[2] OUT[1] OUT[0] vdd
** GLOBAL gnd
** GLOBAL vdd
Xinverter@0 A[3] net@3 SRAM_jelib__inverter
Xinverter@1 A[2] net@7 SRAM_jelib__inverter
Xinverter@2 A[1] net@11 SRAM_jelib__inverter
Xinverter@3 A[0] net@15 SRAM_jelib__inverter
Xinverter@4 net@16 OUT[0] SRAM_jelib__inverter
Xinverter@5 net@22 OUT[1] SRAM_jelib__inverter
Xinverter@6 net@28 OUT[2] SRAM_jelib__inverter
Xinverter@7 net@34 OUT[3] SRAM_jelib__inverter
Xinverter@8 net@40 OUT[4] SRAM_jelib__inverter
Xinverter@9 net@46 OUT[5] SRAM_jelib__inverter
Xinverter@10 net@52 OUT[6] SRAM_jelib__inverter
Xinverter@11 net@58 OUT[7] SRAM_jelib__inverter
Xinverter@12 net@64 OUT[8] SRAM_jelib__inverter
Xinverter@13 net@70 OUT[9] SRAM_jelib__inverter
Xinverter@14 net@76 OUT[10] SRAM_jelib__inverter
Xinverter@15 net@82 OUT[11] SRAM_jelib__inverter
Xinverter@16 net@88 OUT[12] SRAM_jelib__inverter
Xinverter@17 net@94 OUT[13] SRAM_jelib__inverter
Xinverter@18 net@100 OUT[14] SRAM_jelib__inverter
Xinverter@19 net@106 OUT[15] SRAM_jelib__inverter
Xnand4@0 net@3 net@7 net@11 net@15 net@16 SRAM_jelib__nand4
Xnand4@1 net@3 net@7 net@11 A[0] net@22 SRAM_jelib__nand4
Xnand4@2 net@3 net@7 A[1] net@15 net@28 SRAM_jelib__nand4
Xnand4@3 net@3 net@7 A[1] A[0] net@34 SRAM_jelib__nand4
Xnand4@4 net@3 A[2] net@11 net@15 net@40 SRAM_jelib__nand4
Xnand4@5 net@3 A[2] net@11 A[0] net@46 SRAM_jelib__nand4
Xnand4@6 net@3 A[2] A[1] net@15 net@52 SRAM_jelib__nand4
Xnand4@7 net@3 A[2] A[1] A[0] net@58 SRAM_jelib__nand4
Xnand4@8 A[3] net@7 net@11 net@15 net@64 SRAM_jelib__nand4
Xnand4@9 A[3] net@7 net@11 A[0] net@70 SRAM_jelib__nand4
Xnand4@10 A[3] net@7 A[1] net@15 net@76 SRAM_jelib__nand4
Xnand4@11 A[3] net@7 A[1] A[0] net@82 SRAM_jelib__nand4
Xnand4@12 A[3] A[2] net@11 net@15 net@88 SRAM_jelib__nand4
Xnand4@13 A[3] A[2] net@11 A[0] net@94 SRAM_jelib__nand4
Xnand4@14 A[3] A[2] A[1] net@15 net@100 SRAM_jelib__nand4
Xnand4@15 A[3] A[2] A[1] A[0] net@106 SRAM_jelib__nand4
.ENDS SRAM_jelib__Decoder_4x16

*** SUBCIRCUIT SRAM_jelib__tgate FROM CELL SRAM.jelib:tgate{sch}
.SUBCKT SRAM_jelib__tgate EN ENB gnd IN OUT vdd
** GLOBAL gnd
** GLOBAL vdd
Mnmos@0 IN EN OUT gnd CMOSN L=0.4U W=1.6U
Mpmos@0 OUT ENB IN vdd CMOSP L=0.4U W=2.4U
.ENDS SRAM_jelib__tgate

*** SUBCIRCUIT SRAM_jelib__DFF FROM CELL SRAM.jelib:DFF{sch}
.SUBCKT SRAM_jelib__DFF CLK D gnd Q vdd
** GLOBAL gnd
** GLOBAL vdd
XINV1 CLK net@20 SRAM_jelib__inverter
XINV2 net@20 net@22 SRAM_jelib__inverter
XINV3 net@1 net@3 SRAM_jelib__inverter
XINV4 net@3 net@12 SRAM_jelib__inverter
XINV5 net@5 net@7 SRAM_jelib__inverter
XINV6 net@7 Q SRAM_jelib__inverter
XTG1 net@20 net@22 gnd D net@1 vdd SRAM_jelib__tgate
XTG2 net@22 net@20 gnd net@12 net@1 vdd SRAM_jelib__tgate
XTG3 net@22 net@20 gnd net@3 net@5 vdd SRAM_jelib__tgate
XTG4 net@20 net@22 gnd net@7 net@5 vdd SRAM_jelib__tgate
.ENDS SRAM_jelib__DFF

*** SUBCIRCUIT SRAM_jelib__Div8_Counter FROM CELL SRAM.jelib:Div8_Counter{sch}
.SUBCKT SRAM_jelib__Div8_Counter CLK EXECUTE gnd vdd
** GLOBAL gnd
** GLOBAL vdd
XDFF@0 CLK net@7 gnd net@24 vdd SRAM_jelib__DFF
XDFF@1 net@7 net@9 gnd net@31 vdd SRAM_jelib__DFF
XDFF@2 net@9 net@11 gnd net@38 vdd SRAM_jelib__DFF
Xinverter@0 net@24 net@7 SRAM_jelib__inverter
Xinverter@1 net@31 net@9 SRAM_jelib__inverter
Xinverter@2 net@38 net@11 SRAM_jelib__inverter
Xinverter@3 net@49 EXECUTE SRAM_jelib__inverter
Xnand4@0 net@24 net@31 net@38 vdd net@49 SRAM_jelib__nand4
.ENDS SRAM_jelib__Div8_Counter

*** SUBCIRCUIT SRAM_jelib__col_mux_1x FROM CELL SRAM.jelib:col_mux_1x{sch}
.SUBCKT SRAM_jelib__col_mux_1x BL BLB COL_SEL COL_SEL_B GBL GBLB gnd vdd
** GLOBAL gnd
** GLOBAL vdd
Xtgate@0 COL_SEL COL_SEL_B gnd BL GBL vdd SRAM_jelib__tgate
Xtgate@1 COL_SEL COL_SEL_B gnd BLB GBLB vdd SRAM_jelib__tgate
.ENDS SRAM_jelib__col_mux_1x

*** SUBCIRCUIT SRAM_jelib__Col_Mux_Bank_16 FROM CELL SRAM.jelib:Col_Mux_Bank_16{sch}
.SUBCKT SRAM_jelib__Col_Mux_Bank_16 BL[15] BL[14] BL[13] BL[12] BL[11] BL[10] BL[9] BL[8] BL[7] BL[6] BL[5] BL[4] BL[3] BL[2] BL[1] BL[0] BLB[15] BLB[14] BLB[13] BLB[12] BLB[11] BLB[10] BLB[9] BLB[8] BLB[7] BLB[6] BLB[5] BLB[4] BLB[3] BLB[2] BLB[1] BLB[0] COL_SEL[15] COL_SEL[14] COL_SEL[13] COL_SEL[12] COL_SEL[11] COL_SEL[10] COL_SEL[9] COL_SEL[8] COL_SEL[7] COL_SEL[6] COL_SEL[5] COL_SEL[4] COL_SEL[3] COL_SEL[2] COL_SEL[1] COL_SEL[0] COL_SEL_B[15] COL_SEL_B[14] COL_SEL_B[13] COL_SEL_B[12] COL_SEL_B[11]
+COL_SEL_B[10] COL_SEL_B[9] COL_SEL_B[8] COL_SEL_B[7] COL_SEL_B[6] COL_SEL_B[5] COL_SEL_B[4] COL_SEL_B[3] COL_SEL_B[2] COL_SEL_B[1] COL_SEL_B[0] GBL GBLB gnd vdd
** GLOBAL gnd
** GLOBAL vdd
Xcol_mux_@0 BL[0] BLB[0] COL_SEL[0] COL_SEL_B[0] GBL GBLB gnd vdd SRAM_jelib__col_mux_1x
Xcol_mux_@1 BL[1] BLB[1] COL_SEL[1] COL_SEL_B[1] GBL GBLB gnd vdd SRAM_jelib__col_mux_1x
Xcol_mux_@2 BL[2] BLB[2] COL_SEL[2] COL_SEL_B[2] GBL GBLB gnd vdd SRAM_jelib__col_mux_1x
Xcol_mux_@3 BL[3] BLB[3] COL_SEL[3] COL_SEL_B[3] GBL GBLB gnd vdd SRAM_jelib__col_mux_1x
Xcol_mux_@4 BL[4] BLB[4] COL_SEL[4] COL_SEL_B[4] GBL GBLB gnd vdd SRAM_jelib__col_mux_1x
Xcol_mux_@5 BL[5] BLB[5] COL_SEL[5] COL_SEL_B[5] GBL GBLB gnd vdd SRAM_jelib__col_mux_1x
Xcol_mux_@6 BL[6] BLB[6] COL_SEL[6] COL_SEL_B[6] GBL GBLB gnd vdd SRAM_jelib__col_mux_1x
Xcol_mux_@7 BL[7] BLB[7] COL_SEL[7] COL_SEL_B[7] GBL GBLB gnd vdd SRAM_jelib__col_mux_1x
Xcol_mux_@8 BL[8] BLB[8] COL_SEL[8] COL_SEL_B[8] GBL GBLB gnd vdd SRAM_jelib__col_mux_1x
Xcol_mux_@9 BL[9] BLB[9] COL_SEL[9] COL_SEL_B[9] GBL GBLB gnd vdd SRAM_jelib__col_mux_1x
Xcol_mux_@10 BL[10] BLB[10] COL_SEL[10] COL_SEL_B[10] GBL GBLB gnd vdd SRAM_jelib__col_mux_1x
Xcol_mux_@11 BL[11] BLB[11] COL_SEL[11] COL_SEL_B[11] GBL GBLB gnd vdd SRAM_jelib__col_mux_1x
Xcol_mux_@12 BL[12] BLB[12] COL_SEL[12] COL_SEL_B[12] GBL GBLB gnd vdd SRAM_jelib__col_mux_1x
Xcol_mux_@13 BL[13] BLB[13] COL_SEL[13] COL_SEL_B[13] GBL GBLB gnd vdd SRAM_jelib__col_mux_1x
Xcol_mux_@14 BL[14] BLB[14] COL_SEL[14] COL_SEL_B[14] GBL GBLB gnd vdd SRAM_jelib__col_mux_1x
Xcol_mux_@15 BL[15] BLB[15] COL_SEL[15] COL_SEL_B[15] GBL GBLB gnd vdd SRAM_jelib__col_mux_1x
.ENDS SRAM_jelib__Col_Mux_Bank_16

*** SUBCIRCUIT SRAM_jelib__pre_charge FROM CELL SRAM.jelib:pre_charge{sch}
.SUBCKT SRAM_jelib__pre_charge BL BLB PRE vdd
** GLOBAL vdd
Mpmos@0 vdd PRE BLB vdd CMOSP L=0.4U W=1.6U
Mpmos@1 BL PRE vdd vdd CMOSP L=0.4U W=1.6U
Mpmos@2 BLB PRE BL vdd CMOSP L=0.4U W=1.6U
.ENDS SRAM_jelib__pre_charge

*** SUBCIRCUIT SRAM_jelib__Precharge_Bank_16 FROM CELL SRAM.jelib:Precharge_Bank_16{sch}
.SUBCKT SRAM_jelib__Precharge_Bank_16 BL[15] BL[14] BL[13] BL[12] BL[11] BL[10] BL[9] BL[8] BL[7] BL[6] BL[5] BL[4] BL[3] BL[2] BL[1] BL[0] BLB[15] BLB[14] BLB[13] BLB[12] BLB[11] BLB[10] BLB[9] BLB[8] BLB[7] BLB[6] BLB[5] BLB[4] BLB[3] BLB[2] BLB[1] BLB[0] gnd PRE_B vdd
** GLOBAL gnd
** GLOBAL vdd
Xpre_char@0 BL[0] BLB[0] PRE_B vdd SRAM_jelib__pre_charge
Xpre_char@1 BL[1] BLB[1] PRE_B vdd SRAM_jelib__pre_charge
Xpre_char@2 BL[2] BLB[2] PRE_B vdd SRAM_jelib__pre_charge
Xpre_char@3 BL[3] BLB[3] PRE_B vdd SRAM_jelib__pre_charge
Xpre_char@4 BL[4] BLB[4] PRE_B vdd SRAM_jelib__pre_charge
Xpre_char@5 BL[5] BLB[5] PRE_B vdd SRAM_jelib__pre_charge
Xpre_char@6 BL[6] BLB[6] PRE_B vdd SRAM_jelib__pre_charge
Xpre_char@7 BL[7] BLB[7] PRE_B vdd SRAM_jelib__pre_charge
Xpre_char@8 BL[8] BLB[8] PRE_B vdd SRAM_jelib__pre_charge
Xpre_char@9 BL[9] BLB[9] PRE_B vdd SRAM_jelib__pre_charge
Xpre_char@10 BL[10] BLB[10] PRE_B vdd SRAM_jelib__pre_charge
Xpre_char@11 BL[11] BLB[11] PRE_B vdd SRAM_jelib__pre_charge
Xpre_char@12 BL[12] BLB[12] PRE_B vdd SRAM_jelib__pre_charge
Xpre_char@13 BL[13] BLB[13] PRE_B vdd SRAM_jelib__pre_charge
Xpre_char@14 BL[14] BLB[14] PRE_B vdd SRAM_jelib__pre_charge
Xpre_char@15 BL[15] BLB[15] PRE_B vdd SRAM_jelib__pre_charge
.ENDS SRAM_jelib__Precharge_Bank_16

*** SUBCIRCUIT SRAM_jelib__6T FROM CELL SRAM.jelib:6T{sch}
.SUBCKT SRAM_jelib__6T BL BLB gnd vdd WL
** GLOBAL gnd
** GLOBAL vdd
Mnmos@0 net@4 net@9 gnd gnd cmosn L=0.4U W=1.2U
Mnmos@1 net@9 net@4 gnd gnd cmosn L=0.4U W=1.2U
Mnmos@2 BL WL net@9 gnd cmosn L=0.4U W=0.8U
Mnmos@3 net@4 WL BLB gnd cmosn L=0.4U W=0.8U
Mpmos@0 vdd net@4 net@9 vdd cmosp L=0.4U W=0.6U
Mpmos@1 vdd net@9 net@4 vdd cmosp L=0.4U W=0.6U
.ENDS SRAM_jelib__6T

*** SUBCIRCUIT SRAM_jelib__SRAM_Row_16 FROM CELL SRAM.jelib:SRAM_Row_16{sch}
.SUBCKT SRAM_jelib__SRAM_Row_16 BL[15] BL[14] BL[13] BL[12] BL[11] BL[10] BL[9] BL[8] BL[7] BL[6] BL[5] BL[4] BL[3] BL[2] BL[1] BL[0] BLB[15] BLB[14] BLB[13] BLB[12] BLB[11] BLB[10] BLB[9] BLB[8] BLB[7] BLB[6] BLB[5] BLB[4] BLB[3] BLB[2] BLB[1] BLB[0] gnd vdd WL
** GLOBAL gnd
** GLOBAL vdd
X_6T@0 BL[0] BLB[0] gnd vdd WL SRAM_jelib__6T
X_6T@1 BL[1] BLB[1] gnd vdd WL SRAM_jelib__6T
X_6T@2 BL[2] BLB[2] gnd vdd WL SRAM_jelib__6T
X_6T@3 BL[3] BLB[3] gnd vdd WL SRAM_jelib__6T
X_6T@4 BL[4] BLB[4] gnd vdd WL SRAM_jelib__6T
X_6T@5 BL[5] BLB[5] gnd vdd WL SRAM_jelib__6T
X_6T@6 BL[6] BLB[6] gnd vdd WL SRAM_jelib__6T
X_6T@7 BL[7] BLB[7] gnd vdd WL SRAM_jelib__6T
X_6T@8 BL[8] BLB[8] gnd vdd WL SRAM_jelib__6T
X_6T@9 BL[9] BLB[9] gnd vdd WL SRAM_jelib__6T
X_6T@10 BL[10] BLB[10] gnd vdd WL SRAM_jelib__6T
X_6T@11 BL[11] BLB[11] gnd vdd WL SRAM_jelib__6T
X_6T@12 BL[12] BLB[12] gnd vdd WL SRAM_jelib__6T
X_6T@13 BL[13] BLB[13] gnd vdd WL SRAM_jelib__6T
X_6T@14 BL[14] BLB[14] gnd vdd WL SRAM_jelib__6T
X_6T@15 BL[15] BLB[15] gnd vdd WL SRAM_jelib__6T
.ENDS SRAM_jelib__SRAM_Row_16

*** SUBCIRCUIT SRAM_jelib__SRAM_Array_16x16 FROM CELL SRAM.jelib:SRAM_Array_16x16{sch}
.SUBCKT SRAM_jelib__SRAM_Array_16x16 BL[15] BL[14] BL[13] BL[12] BL[11] BL[10] BL[9] BL[8] BL[7] BL[6] BL[5] BL[4] BL[3] BL[2] BL[1] BL[0] BLB[15] BLB[14] BLB[13] BLB[12] BLB[11] BLB[10] BLB[9] BLB[8] BLB[7] BLB[6] BLB[5] BLB[4] BLB[3] BLB[2] BLB[1] BLB[0] gnd vdd WL[15] WL[14] WL[13] WL[12] WL[11] WL[10] WL[9] WL[8] WL[7] WL[6] WL[5] WL[4] WL[3] WL[2] WL[1] WL[0]
** GLOBAL gnd
** GLOBAL vdd
XSRAM_Row@0 BL[15] BL[14] BL[13] BL[12] BL[11] BL[10] BL[9] BL[8] BL[7] BL[6] BL[5] BL[4] BL[3] BL[2] BL[1] BL[0] BLB[15] BLB[14] BLB[13] BLB[12] BLB[11] BLB[10] BLB[9] BLB[8] BLB[7] BLB[6] BLB[5] BLB[4] BLB[3] BLB[2] BLB[1] BLB[0] gnd vdd WL[0] SRAM_jelib__SRAM_Row_16
XSRAM_Row@1 BL[15] BL[14] BL[13] BL[12] BL[11] BL[10] BL[9] BL[8] BL[7] BL[6] BL[5] BL[4] BL[3] BL[2] BL[1] BL[0] BLB[15] BLB[14] BLB[13] BLB[12] BLB[11] BLB[10] BLB[9] BLB[8] BLB[7] BLB[6] BLB[5] BLB[4] BLB[3] BLB[2] BLB[1] BLB[0] gnd vdd WL[1] SRAM_jelib__SRAM_Row_16
XSRAM_Row@2 BL[15] BL[14] BL[13] BL[12] BL[11] BL[10] BL[9] BL[8] BL[7] BL[6] BL[5] BL[4] BL[3] BL[2] BL[1] BL[0] BLB[15] BLB[14] BLB[13] BLB[12] BLB[11] BLB[10] BLB[9] BLB[8] BLB[7] BLB[6] BLB[5] BLB[4] BLB[3] BLB[2] BLB[1] BLB[0] gnd vdd WL[2] SRAM_jelib__SRAM_Row_16
XSRAM_Row@3 BL[15] BL[14] BL[13] BL[12] BL[11] BL[10] BL[9] BL[8] BL[7] BL[6] BL[5] BL[4] BL[3] BL[2] BL[1] BL[0] BLB[15] BLB[14] BLB[13] BLB[12] BLB[11] BLB[10] BLB[9] BLB[8] BLB[7] BLB[6] BLB[5] BLB[4] BLB[3] BLB[2] BLB[1] BLB[0] gnd vdd WL[3] SRAM_jelib__SRAM_Row_16
XSRAM_Row@4 BL[15] BL[14] BL[13] BL[12] BL[11] BL[10] BL[9] BL[8] BL[7] BL[6] BL[5] BL[4] BL[3] BL[2] BL[1] BL[0] BLB[15] BLB[14] BLB[13] BLB[12] BLB[11] BLB[10] BLB[9] BLB[8] BLB[7] BLB[6] BLB[5] BLB[4] BLB[3] BLB[2] BLB[1] BLB[0] gnd vdd WL[4] SRAM_jelib__SRAM_Row_16
XSRAM_Row@5 BL[15] BL[14] BL[13] BL[12] BL[11] BL[10] BL[9] BL[8] BL[7] BL[6] BL[5] BL[4] BL[3] BL[2] BL[1] BL[0] BLB[15] BLB[14] BLB[13] BLB[12] BLB[11] BLB[10] BLB[9] BLB[8] BLB[7] BLB[6] BLB[5] BLB[4] BLB[3] BLB[2] BLB[1] BLB[0] gnd vdd WL[5] SRAM_jelib__SRAM_Row_16
XSRAM_Row@6 BL[15] BL[14] BL[13] BL[12] BL[11] BL[10] BL[9] BL[8] BL[7] BL[6] BL[5] BL[4] BL[3] BL[2] BL[1] BL[0] BLB[15] BLB[14] BLB[13] BLB[12] BLB[11] BLB[10] BLB[9] BLB[8] BLB[7] BLB[6] BLB[5] BLB[4] BLB[3] BLB[2] BLB[1] BLB[0] gnd vdd WL[6] SRAM_jelib__SRAM_Row_16
XSRAM_Row@7 BL[15] BL[14] BL[13] BL[12] BL[11] BL[10] BL[9] BL[8] BL[7] BL[6] BL[5] BL[4] BL[3] BL[2] BL[1] BL[0] BLB[15] BLB[14] BLB[13] BLB[12] BLB[11] BLB[10] BLB[9] BLB[8] BLB[7] BLB[6] BLB[5] BLB[4] BLB[3] BLB[2] BLB[1] BLB[0] gnd vdd WL[7] SRAM_jelib__SRAM_Row_16
XSRAM_Row@8 BL[15] BL[14] BL[13] BL[12] BL[11] BL[10] BL[9] BL[8] BL[7] BL[6] BL[5] BL[4] BL[3] BL[2] BL[1] BL[0] BLB[15] BLB[14] BLB[13] BLB[12] BLB[11] BLB[10] BLB[9] BLB[8] BLB[7] BLB[6] BLB[5] BLB[4] BLB[3] BLB[2] BLB[1] BLB[0] gnd vdd WL[8] SRAM_jelib__SRAM_Row_16
XSRAM_Row@9 BL[15] BL[14] BL[13] BL[12] BL[11] BL[10] BL[9] BL[8] BL[7] BL[6] BL[5] BL[4] BL[3] BL[2] BL[1] BL[0] BLB[15] BLB[14] BLB[13] BLB[12] BLB[11] BLB[10] BLB[9] BLB[8] BLB[7] BLB[6] BLB[5] BLB[4] BLB[3] BLB[2] BLB[1] BLB[0] gnd vdd WL[9] SRAM_jelib__SRAM_Row_16
XSRAM_Row@10 BL[15] BL[14] BL[13] BL[12] BL[11] BL[10] BL[9] BL[8] BL[7] BL[6] BL[5] BL[4] BL[3] BL[2] BL[1] BL[0] BLB[15] BLB[14] BLB[13] BLB[12] BLB[11] BLB[10] BLB[9] BLB[8] BLB[7] BLB[6] BLB[5] BLB[4] BLB[3] BLB[2] BLB[1] BLB[0] gnd vdd WL[10] SRAM_jelib__SRAM_Row_16
XSRAM_Row@11 BL[15] BL[14] BL[13] BL[12] BL[11] BL[10] BL[9] BL[8] BL[7] BL[6] BL[5] BL[4] BL[3] BL[2] BL[1] BL[0] BLB[15] BLB[14] BLB[13] BLB[12] BLB[11] BLB[10] BLB[9] BLB[8] BLB[7] BLB[6] BLB[5] BLB[4] BLB[3] BLB[2] BLB[1] BLB[0] gnd vdd WL[11] SRAM_jelib__SRAM_Row_16
XSRAM_Row@12 BL[15] BL[14] BL[13] BL[12] BL[11] BL[10] BL[9] BL[8] BL[7] BL[6] BL[5] BL[4] BL[3] BL[2] BL[1] BL[0] BLB[15] BLB[14] BLB[13] BLB[12] BLB[11] BLB[10] BLB[9] BLB[8] BLB[7] BLB[6] BLB[5] BLB[4] BLB[3] BLB[2] BLB[1] BLB[0] gnd vdd WL[12] SRAM_jelib__SRAM_Row_16
XSRAM_Row@13 BL[15] BL[14] BL[13] BL[12] BL[11] BL[10] BL[9] BL[8] BL[7] BL[6] BL[5] BL[4] BL[3] BL[2] BL[1] BL[0] BLB[15] BLB[14] BLB[13] BLB[12] BLB[11] BLB[10] BLB[9] BLB[8] BLB[7] BLB[6] BLB[5] BLB[4] BLB[3] BLB[2] BLB[1] BLB[0] gnd vdd WL[13] SRAM_jelib__SRAM_Row_16
XSRAM_Row@14 BL[15] BL[14] BL[13] BL[12] BL[11] BL[10] BL[9] BL[8] BL[7] BL[6] BL[5] BL[4] BL[3] BL[2] BL[1] BL[0] BLB[15] BLB[14] BLB[13] BLB[12] BLB[11] BLB[10] BLB[9] BLB[8] BLB[7] BLB[6] BLB[5] BLB[4] BLB[3] BLB[2] BLB[1] BLB[0] gnd vdd WL[14] SRAM_jelib__SRAM_Row_16
XSRAM_Row@15 BL[15] BL[14] BL[13] BL[12] BL[11] BL[10] BL[9] BL[8] BL[7] BL[6] BL[5] BL[4] BL[3] BL[2] BL[1] BL[0] BLB[15] BLB[14] BLB[13] BLB[12] BLB[11] BLB[10] BLB[9] BLB[8] BLB[7] BLB[6] BLB[5] BLB[4] BLB[3] BLB[2] BLB[1] BLB[0] gnd vdd WL[15] SRAM_jelib__SRAM_Row_16
.ENDS SRAM_jelib__SRAM_Array_16x16

*** SUBCIRCUIT SRAM_jelib__SRAM_Core_Datapath FROM CELL SRAM.jelib:SRAM_Core_Datapath{sch}
.SUBCKT SRAM_jelib__SRAM_Core_Datapath COL_SEL[15] COL_SEL[14] COL_SEL[13] COL_SEL[12] COL_SEL[11] COL_SEL[10] COL_SEL[9] COL_SEL[8] COL_SEL[7] COL_SEL[6] COL_SEL[5] COL_SEL[4] COL_SEL[3] COL_SEL[2] COL_SEL[1] COL_SEL[0] COL_SEL_B[15] COL_SEL_B[14] COL_SEL_B[13] COL_SEL_B[12] COL_SEL_B[11] COL_SEL_B[10] COL_SEL_B[9] COL_SEL_B[8] COL_SEL_B[7] COL_SEL_B[6] COL_SEL_B[5] COL_SEL_B[4] COL_SEL_B[3] COL_SEL_B[2] COL_SEL_B[1] COL_SEL_B[0] GBL GBLB gnd PRE_B vdd WL[15] WL[14] WL[13] WL[12] WL[11] WL[10] WL[9] WL[8]
+WL[7] WL[6] WL[5] WL[4] WL[3] WL[2] WL[1] WL[0]
** GLOBAL gnd
** GLOBAL vdd
XCol_Mux_@0 net@60 net@56 net@52 net@48 net@44 net@40 net@36 net@32 net@28 net@24 net@20 net@16 net@12 net@8 net@4 net@0 net@61 net@57 net@53 net@49 net@45 net@41 net@37 net@33 net@29 net@25 net@21 net@17 net@13 net@9 net@5 net@1 COL_SEL[15] COL_SEL[14] COL_SEL[13] COL_SEL[12] COL_SEL[11] COL_SEL[10] COL_SEL[9] COL_SEL[8] COL_SEL[7] COL_SEL[6] COL_SEL[5] COL_SEL[4] COL_SEL[3] COL_SEL[2] COL_SEL[1] COL_SEL[0] COL_SEL_B[15] COL_SEL_B[14] COL_SEL_B[13] COL_SEL_B[12] COL_SEL_B[11] COL_SEL_B[10] COL_SEL_B[9]
+COL_SEL_B[8] COL_SEL_B[7] COL_SEL_B[6] COL_SEL_B[5] COL_SEL_B[4] COL_SEL_B[3] COL_SEL_B[2] COL_SEL_B[1] COL_SEL_B[0] GBL GBLB gnd vdd SRAM_jelib__Col_Mux_Bank_16
XPrecharg@0 net@60 net@56 net@52 net@48 net@44 net@40 net@36 net@32 net@28 net@24 net@20 net@16 net@12 net@8 net@4 net@0 net@61 net@57 net@53 net@49 net@45 net@41 net@37 net@33 net@29 net@25 net@21 net@17 net@13 net@9 net@5 net@1 gnd PRE_B vdd SRAM_jelib__Precharge_Bank_16
XSRAM_Arr@0 net@60 net@56 net@52 net@48 net@44 net@40 net@36 net@32 net@28 net@24 net@20 net@16 net@12 net@8 net@4 net@0 net@61 net@57 net@53 net@49 net@45 net@41 net@37 net@33 net@29 net@25 net@21 net@17 net@13 net@9 net@5 net@1 gnd vdd WL[15] WL[14] WL[13] WL[12] WL[11] WL[10] WL[9] WL[8] WL[7] WL[6] WL[5] WL[4] WL[3] WL[2] WL[1] WL[0] SRAM_jelib__SRAM_Array_16x16
.ENDS SRAM_jelib__SRAM_Core_Datapath

*** SUBCIRCUIT SRAM_jelib__ShiftReg_8bit FROM CELL SRAM.jelib:ShiftReg_8bit{sch}
.SUBCKT SRAM_jelib__ShiftReg_8bit ADDR_IN CLK gnd Q[7] Q[6] Q[5] Q[4] Q[3] Q[2] Q[1] Q[0] vdd
** GLOBAL gnd
** GLOBAL vdd
XDFF@0 CLK ADDR_IN gnd Q[0] vdd SRAM_jelib__DFF
XDFF@1 CLK Q[0] gnd Q[1] vdd SRAM_jelib__DFF
XDFF@2 CLK Q[1] gnd Q[2] vdd SRAM_jelib__DFF
XDFF@3 CLK Q[2] gnd Q[3] vdd SRAM_jelib__DFF
XDFF@4 CLK Q[3] gnd Q[4] vdd SRAM_jelib__DFF
XDFF@5 CLK Q[4] gnd Q[5] vdd SRAM_jelib__DFF
XDFF@6 CLK Q[5] gnd Q[6] vdd SRAM_jelib__DFF
XDFF@7 CLK Q[6] gnd Q[7] vdd SRAM_jelib__DFF
.ENDS SRAM_jelib__ShiftReg_8bit

*** SUBCIRCUIT SRAM_jelib__sense_amplifier FROM CELL SRAM.jelib:sense_amplifier{sch}
.SUBCKT SRAM_jelib__sense_amplifier BL BLB gnd SAE SO SOB vdd
** GLOBAL gnd
** GLOBAL vdd
Mnmos@0 net@9 BL net@3 gnd CMOSN L=0.4U W=0.8U
Mnmos@1 net@3 BLB SO gnd CMOSN L=0.4U W=0.8U
Mnmos@2 net@3 SAE gnd gnd CMOSN L=0.4U W=1.6U
Mpmos@0 net@9 net@9 vdd vdd CMOSP L=0.4U W=3.2U
Mpmos@1 vdd net@9 SO vdd CMOSP L=0.4U W=3.2U
Xinverter@1 SO SOB SRAM_jelib__inverter
.ENDS SRAM_jelib__sense_amplifier

*** SUBCIRCUIT SRAM_jelib__write_driver FROM CELL SRAM.jelib:write_driver{sch}
.SUBCKT SRAM_jelib__write_driver BL BLB gnd vdd WD WE
** GLOBAL gnd
** GLOBAL vdd
Mnmos@0 BL WE net@0 gnd CMOSN L=0.4U W=2.4U
Mnmos@1 BLB WE net@1 gnd CMOSN L=0.4U W=2.4U
Mnmos@2 net@1 net@3 gnd gnd CMOSN L=0.4U W=2.4U
Mnmos@3 gnd WD net@0 gnd CMOSN L=0.4U W=2.4U
Mnmos@4 net@3 WD gnd gnd CMOSN L=0.4U W=0.8U
Mpmos@0 vdd WD net@3 vdd CMOSP L=0.4U W=1.6U
.ENDS SRAM_jelib__write_driver

*** SUBCIRCUIT SRAM_jelib__SRAM_256_Macro FROM CELL SRAM.jelib:SRAM_256_Macro{sch}
.SUBCKT SRAM_jelib__SRAM_256_Macro ADDR_IN CLK DIN DOUT gnd R_W vdd
** GLOBAL gnd
** GLOBAL vdd
XDecoder_@0 net@24 net@22 net@20 net@18 gnd net@41 net@40 net@39 net@38 net@37 net@36 net@35 net@34 net@33 net@32 net@31 net@30 net@29 net@28 net@27 net@26 vdd SRAM_jelib__Decoder_4x16
XDecoder_@1 net@25 net@23 net@21 net@19 gnd net@87 net@84 net@81 net@78 net@75 net@72 net@69 net@66 net@63 net@60 net@57 net@54 net@51 net@48 net@45 net@42 vdd SRAM_jelib__Decoder_4x16
XDiv8_Cou@0 CLK net@94 gnd vdd SRAM_jelib__Div8_Counter
XSRAM_Cor@0 net@87 net@84 net@81 net@78 net@75 net@72 net@69 net@66 net@63 net@60 net@57 net@54 net@51 net@48 net@45 net@42 net@89 net@86 net@83 net@80 net@77 net@74 net@71 net@68 net@65 net@62 net@59 net@56 net@53 net@50 net@47 net@44 net@90 net@92 gnd net@94 vdd net@41 net@40 net@39 net@38 net@37 net@36 net@35 net@34 net@33 net@32 net@31 net@30 net@29 net@28 net@27 net@26 SRAM_jelib__SRAM_Core_Datapath
XShiftReg@0 ADDR_IN CLK gnd net@25 net@23 net@21 net@19 net@24 net@22 net@20 net@18 vdd SRAM_jelib__ShiftReg_8bit
Xinverter@0 net@42 net@44 SRAM_jelib__inverter
Xinverter@1 net@45 net@47 SRAM_jelib__inverter
Xinverter@2 net@48 net@50 SRAM_jelib__inverter
Xinverter@3 net@51 net@53 SRAM_jelib__inverter
Xinverter@4 net@54 net@56 SRAM_jelib__inverter
Xinverter@5 net@57 net@59 SRAM_jelib__inverter
Xinverter@6 net@60 net@62 SRAM_jelib__inverter
Xinverter@7 net@63 net@65 SRAM_jelib__inverter
Xinverter@8 net@66 net@68 SRAM_jelib__inverter
Xinverter@9 net@69 net@71 SRAM_jelib__inverter
Xinverter@10 net@72 net@74 SRAM_jelib__inverter
Xinverter@11 net@75 net@77 SRAM_jelib__inverter
Xinverter@12 net@78 net@80 SRAM_jelib__inverter
Xinverter@13 net@81 net@83 SRAM_jelib__inverter
Xinverter@14 net@84 net@86 SRAM_jelib__inverter
Xinverter@15 net@87 net@89 SRAM_jelib__inverter
Xinverter@16 net@94 net@96 SRAM_jelib__inverter
Xinverter@17 net@96 net@97 SRAM_jelib__inverter
Xinverter@18 net@97 net@99 SRAM_jelib__inverter
Xinverter@19 R_W net@102 SRAM_jelib__inverter
Xinverter@20 net@103 net@104 SRAM_jelib__inverter
Xinverter@21 net@105 net@106 SRAM_jelib__inverter
Xnand4@0 net@97 R_W vdd vdd net@103 SRAM_jelib__nand4
Xnand4@1 net@99 net@102 vdd vdd net@105 SRAM_jelib__nand4
Xsense_am@0 net@90 net@92 gnd net@106 DOUT sense_am@0_SOB vdd SRAM_jelib__sense_amplifier
Xwrite_dr@0 net@90 net@92 gnd vdd DIN net@104 SRAM_jelib__write_driver
.ENDS SRAM_jelib__SRAM_256_Macro

.global gnd vdd

*** TOP LEVEL CELL: SRAM.jelib:SRAM_Chip_Final{sch}
XInput_Pa@0 net@0 gnd pad_CLK vdd SRAM_jelib__Input_Pad
XInput_Pa@1 net@1 gnd pad_ADDR_IN vdd SRAM_jelib__Input_Pad
XInput_Pa@2 net@2 gnd pad_R_W vdd SRAM_jelib__Input_Pad
XInput_Pa@3 net@3 gnd pad_DIN vdd SRAM_jelib__Input_Pad
XOutput_P@0 net@4 gnd pad_DOUT vdd SRAM_jelib__Output_Pad
XSRAM_256@0 net@1 net@0 net@3 net@4 gnd net@2 vdd SRAM_jelib__SRAM_256_Macro
.END
