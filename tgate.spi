*** SPICE deck for cell tgate{sch} from library SRAM
*** Created on Tue Oct 27, 2026 23:17:57
*** Last revised on Wed Oct 28, 2026 02:03:26
*** Written on Mon Nov 16, 2026 18:40:34 by Electric VLSI Design System, version 9.08
*** Layout tech: mocmos, foundry MOSIS
*** UC SPICE *** , MIN_RESIST 4.0, MIN_CAPAC 0.1FF

.global gnd vdd

*** TOP LEVEL CELL: SRAM:tgate{sch}
Mnmos@0 IN EN OUT gnd CMOSN L=0.18U W=0.72U
Mpmos@0 OUT ENB IN vdd CMOSP L=0.18U W=1.08U

* Spice Code nodes in cell cell 'SRAM:tgate{sch}'
.include ./tsmc018.lib
.param VDD = 1.8
VDD1 vdd 0 DC 1.8
* Load capacitor on OUT (representing global bitline load)
Cout OUT 0 50f
* 1. Input signal (IN): ramps from 0V -> 1.8V -> 0V
VIN IN 0 PWL(0n 0 5n 1.8 15n 1.8 20n 0 30n 0)
* 2. Active-high enable (EN):
VEN EN 0 PWL(0n 1.8 22n 1.8 22.1n 0 30n 0)
* 3. Active-low enable (ENB): complementary to EN
VENB ENB 0 PWL(0n 0 22n 0 22.1n 1.8 30n 1.8)
.tran 0.1n 30n
.END
