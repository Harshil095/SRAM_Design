*** SPICE deck for cell ShiftReg_8bit{sch} from library SRAM
*** Created on Tue Nov 17, 2026 21:53:41
*** Last revised on Tue Nov 17, 2026 21:53:41
*** Written on Tue Nov 17, 2026 21:53:41 by Electric VLSI Design System, version 9.08
*** Layout tech: mocmos, foundry MOSIS
*** UC SPICE *** , MIN_RESIST 4.0, MIN_CAPAC 0.1FF

*** SUBCIRCUIT SRAM__inverter FROM CELL SRAM:inverter{sch}
.SUBCKT SRAM__inverter in out
** GLOBAL gnd
** GLOBAL vdd
Mnmos@0 out in gnd gnd CMOSN L=0.4U W=0.8U
Mpmos@0 vdd in out vdd CMOSP L=0.4U W=1.6U
.ENDS SRAM__inverter

*** SUBCIRCUIT SRAM__tgate FROM CELL SRAM:tgate{sch}
.SUBCKT SRAM__tgate EN ENB gnd IN OUT vdd
** GLOBAL gnd
** GLOBAL vdd
Mnmos@0 IN EN OUT gnd CMOSN L=0.4U W=1.6U
Mpmos@0 OUT ENB IN vdd CMOSP L=0.4U W=2.4U
.ENDS SRAM__tgate

*** SUBCIRCUIT SRAM__DFF FROM CELL SRAM:DFF{sch}
.SUBCKT SRAM__DFF CLK D gnd Q vdd
** GLOBAL gnd
** GLOBAL vdd
XINV1 CLK net@20 SRAM__inverter
XINV2 net@20 net@22 SRAM__inverter
XINV3 net@1 net@3 SRAM__inverter
XINV4 net@3 net@12 SRAM__inverter
XINV5 net@5 net@7 SRAM__inverter
XINV6 net@7 Q SRAM__inverter
XTG1 net@20 net@22 gnd D net@1 vdd SRAM__tgate
XTG2 net@22 net@20 gnd net@12 net@1 vdd SRAM__tgate
XTG3 net@22 net@20 gnd net@3 net@5 vdd SRAM__tgate
XTG4 net@20 net@22 gnd net@7 net@5 vdd SRAM__tgate

* Spice Code nodes in cell cell 'SRAM:DFF{sch}'
.include ./tsmc018.lib
.param VDD = 1.8
VDD1 vdd 0 DC 1.8
* DFF transient test: clock 100MHz (period 10ns)
VCLK CLK 0 PULSE(0 1.8 1n 0.1n 0.1n 4.9n 10n)
* Data pattern: D toggles with setup/hold relative to clock edges
VD D 0 PWL(0n 0 7n 0 7.2n 1.8 23n 1.8 23.2n 0 35n 0 35.2n 1.8 60n 1.8)
CQ Q 0 20f
.tran 0.1n 60n
.ENDS SRAM__DFF

.global gnd vdd

*** TOP LEVEL CELL: SRAM:ShiftReg_8bit{sch}
XDFF@0 CLK ADDR_IN gnd Q[0] vdd SRAM__DFF
XDFF@1 CLK Q[0] gnd Q[1] vdd SRAM__DFF
XDFF@2 CLK Q[1] gnd Q[2] vdd SRAM__DFF
XDFF@3 CLK Q[2] gnd Q[3] vdd SRAM__DFF
XDFF@4 CLK Q[3] gnd Q[4] vdd SRAM__DFF
XDFF@5 CLK Q[4] gnd Q[5] vdd SRAM__DFF
XDFF@6 CLK Q[5] gnd Q[6] vdd SRAM__DFF
XDFF@7 CLK Q[6] gnd Q[7] vdd SRAM__DFF
.END
