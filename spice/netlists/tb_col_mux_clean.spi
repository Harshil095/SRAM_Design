*** SPICE deck for cell col_mux_1x{sch} from library SRAM
*** Created on Wed Oct 28, 2026 01:48:37
*** Last revised on Wed Oct 28, 2026 02:01:03
*** Written on Wed Oct 28, 2026 02:01:15 by Electric VLSI Design System, version 9.08
*** Layout tech: mocmos, foundry MOSIS
*** UC SPICE *** , MIN_RESIST 4.0, MIN_CAPAC 0.1FF

*** SUBCIRCUIT SRAM__inverter FROM CELL SRAM:inverter{sch}
.SUBCKT SRAM__inverter in out
** GLOBAL gnd
** GLOBAL vdd
Mnmos@0 out in gnd gnd CMOSN L=0.18U W=0.36U
Mpmos@0 vdd in out vdd CMOSP L=0.18U W=0.72U
.ENDS SRAM__inverter

*** SUBCIRCUIT SRAM__tgate FROM CELL SRAM:tgate{sch}
.SUBCKT SRAM__tgate IN OUT SEL SEL_B
** GLOBAL gnd
** GLOBAL vdd
Mnmos@0 OUT SEL IN gnd CMOSN L=0.18U W=0.72U
Mpmos@0 IN SEL_B OUT vdd CMOSP L=0.18U W=1.08U

.ENDS SRAM__tgate

.global gnd vdd

*** TOP LEVEL CELL: SRAM:col_mux_1x{sch}
Xinverter@0 SEL net@6 SRAM__inverter
Xtgate@0 BL GBL SEL net@6 SRAM__tgate
Xtgate@1 BLB GBLB SEL net@6 SRAM__tgate

* Spice Code nodes in cell cell 'SRAM:col_mux_1x{sch}'
.include ../tsmc018.lib
.param VDD = 1.8
VDD1 vdd 0 DC 1.8
* Load capacitors on Global Bitlines
Cgbl  GBL  0 50f
Cgblb GBLB 0 50f
* Column bitlines carry a Read-0 differential:
* BL = 1.65V (150mV dip), BLB = 1.80V
VBL  BL  0 DC 1.65
VBLB BLB 0 DC 1.80
* Column Select (SEL):
* OFF from 0ns to 5ns (High-Z isolation)
* ON from 5ns to 25ns (passes the bitlines to GBL and GBLB)
* OFF from 25ns to 30ns (isolates again)
VSEL SEL 0 PWL(
+ 0n   0
+ 4.9n 0
+ 5n   1.8
+ 25n  1.8
+ 25.1n 0
+ 30n  0)
.tran 0.1n 30n
.END
