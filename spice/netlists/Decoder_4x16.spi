*** SPICE deck for cell Decoder_4x16{sch} from library SRAM
*** Created on Tue Nov 17, 2026 03:50:58
*** Last revised on Tue Nov 17, 2026 03:50:58
*** Written on Tue Nov 17, 2026 03:50:58 by Electric VLSI Design System, version 9.08
*** Layout tech: mocmos, foundry MOSIS
*** UC SPICE *** , MIN_RESIST 4.0, MIN_CAPAC 0.1FF

*** SUBCIRCUIT SRAM__inverter FROM CELL SRAM:inverter{sch}
.SUBCKT SRAM__inverter in out
** GLOBAL gnd
** GLOBAL vdd
Mnmos@0 out in gnd gnd CMOSN L=0.4U W=0.8U
Mpmos@0 vdd in out vdd CMOSP L=0.4U W=1.6U
.ENDS SRAM__inverter

*** SUBCIRCUIT SRAM__nand4 FROM CELL SRAM:nand4{sch}
.SUBCKT SRAM__nand4 A B C D out
** GLOBAL gnd
** GLOBAL vdd
Mnmos@4 out A net@62 gnd CMOSN L=0.4U W=3.2U
Mnmos@5 net@62 B net@63 gnd CMOSN L=0.4U W=3.2U
Mnmos@6 net@63 C net@64 gnd CMOSN L=0.4U W=3.2U
Mnmos@7 net@64 D gnd gnd CMOSN L=0.4U W=3.2U
Mpmos@4 vdd A out vdd CMOSP L=0.4U W=1.6U
Mpmos@5 vdd B out vdd CMOSP L=0.4U W=1.6U
Mpmos@7 vdd C out vdd CMOSP L=0.4U W=1.6U
Mpmos@8 vdd D out vdd CMOSP L=0.4U W=1.6U
.ENDS SRAM__nand4

.global gnd vdd

*** TOP LEVEL CELL: SRAM:Decoder_4x16{sch}
Xinverter@0 A[3] net@3 SRAM__inverter
Xinverter@1 A[2] net@7 SRAM__inverter
Xinverter@2 A[1] net@11 SRAM__inverter
Xinverter@3 A[0] net@15 SRAM__inverter
Xinverter@4 net@16 OUT[0] SRAM__inverter
Xinverter@5 net@22 OUT[1] SRAM__inverter
Xinverter@6 net@28 OUT[2] SRAM__inverter
Xinverter@7 net@34 OUT[3] SRAM__inverter
Xinverter@8 net@40 OUT[4] SRAM__inverter
Xinverter@9 net@46 OUT[5] SRAM__inverter
Xinverter@10 net@52 OUT[6] SRAM__inverter
Xinverter@11 net@58 OUT[7] SRAM__inverter
Xinverter@12 net@64 OUT[8] SRAM__inverter
Xinverter@13 net@70 OUT[9] SRAM__inverter
Xinverter@14 net@76 OUT[10] SRAM__inverter
Xinverter@15 net@82 OUT[11] SRAM__inverter
Xinverter@16 net@88 OUT[12] SRAM__inverter
Xinverter@17 net@94 OUT[13] SRAM__inverter
Xinverter@18 net@100 OUT[14] SRAM__inverter
Xinverter@19 net@106 OUT[15] SRAM__inverter
Xnand4@0 net@3 net@7 net@11 net@15 net@16 SRAM__nand4
Xnand4@1 net@3 net@7 net@11 A[0] net@22 SRAM__nand4
Xnand4@2 net@3 net@7 A[1] net@15 net@28 SRAM__nand4
Xnand4@3 net@3 net@7 A[1] A[0] net@34 SRAM__nand4
Xnand4@4 net@3 A[2] net@11 net@15 net@40 SRAM__nand4
Xnand4@5 net@3 A[2] net@11 A[0] net@46 SRAM__nand4
Xnand4@6 net@3 A[2] A[1] net@15 net@52 SRAM__nand4
Xnand4@7 net@3 A[2] A[1] A[0] net@58 SRAM__nand4
Xnand4@8 A[3] net@7 net@11 net@15 net@64 SRAM__nand4
Xnand4@9 A[3] net@7 net@11 A[0] net@70 SRAM__nand4
Xnand4@10 A[3] net@7 A[1] net@15 net@76 SRAM__nand4
Xnand4@11 A[3] net@7 A[1] A[0] net@82 SRAM__nand4
Xnand4@12 A[3] A[2] net@11 net@15 net@88 SRAM__nand4
Xnand4@13 A[3] A[2] net@11 A[0] net@94 SRAM__nand4
Xnand4@14 A[3] A[2] A[1] net@15 net@100 SRAM__nand4
Xnand4@15 A[3] A[2] A[1] A[0] net@106 SRAM__nand4
.END
