* Butterfly Curve Hold SNM Testbench for 6T SRAM Cell (WL = 0)
.include "../tsmc018.lib"

Vdd vdd 0 DC 1.8

.param WPD_val = 0.54u
.param WPG_val = 0.36u
.param WPU_val = 0.28u
.param L_val   = 0.18u

* For Hold SNM: WL = 0V
Vwl wl 0 DC 0
Vbl bl 0 DC 1.8
Vblb blb 0 DC 1.8

* Half-Cell 1
V_in1 q_in 0 DC 0
Mpd1 qb_out q_in 0   0   CMOSN W={WPD_val} L={L_val}
Mpu1 qb_out q_in vdd vdd CMOSP W={WPU_val} L={L_val}
Mpg1 blb    wl   qb_out 0 CMOSN W={WPG_val} L={L_val}

.control
dc V_in1 0 1.8 0.005
set wr_vecnames
wrdata snm_hold_vtc1.txt v(qb_out)
quit
.endc
.end
