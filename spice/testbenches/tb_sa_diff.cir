* Testbench for Differential Latch Sense Amplifier
.include "../tsmc018.lib"
.include "sense_amp_diff.cir"

Vdd vdd 0 DC 1.8

Xsa bl blb sae so sob vdd 0 sense_amp

Cso  so  0 20f
Csob sob 0 20f

* Case 1: Read-0 (BL drops 150mV to 1.65V, BLB at 1.8V)
* Case 2: Read-1 (BLB drops 150mV to 1.65V, BL at 1.8V)
Vbl bl 0 PWL(
+ 0ns   1.8V
+ 2ns   1.8V
+ 3ns   1.65V
+ 6ns   1.65V
+ 7ns   1.8V
+ 14ns  1.8V)

Vblb blb 0 PWL(
+ 0ns   1.8V
+ 7ns   1.8V
+ 8ns   1.8V
+ 9ns   1.65V
+ 12ns  1.65V
+ 13ns  1.8V
+ 14ns  1.8V)

* SAE pulses high when delta V develops (at 3.5ns and 9.5ns)
Vsae sae 0 PWL(
+ 0ns   0V
+ 3.4ns 0V
+ 3.5ns 1.8V
+ 5.5ns 1.8V
+ 5.6ns 0V
+ 9.4ns 0V
+ 9.5ns 1.8V
+ 11.5ns 1.8V
+ 11.6ns 0V
+ 14.0ns 0V)

.tran 10p 14n

.control
run
set wr_vecnames
wrdata sa_diff_sim.txt v(sae) v(bl) v(blb) v(so) v(sob)
quit
.endc
.end
